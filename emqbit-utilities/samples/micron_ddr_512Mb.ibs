| t37z.ibs * IBIS 4.0 Model
| 512Meg DDR SDRAM - Die Revision "F"
| This Model is valid for Commercial Temperature Range 0C<=Ta<=70C
| Valid for DDR1-266/333/400 operation
| Models *_333 valid for DDR1-266/333 operation
| Models *_400 valid for DDR1-400 operation
| Part Number   VDD/VDDQ   Architecture   Package
| MT46V128M4TG   2.5V or 2.6V   128 Meg x 4   66-pin TSOP
| MT46V64M8TG   2.5V or 2.6V   64 Meg x 8   66-pin TSOP
| MT46V32M16TG   2.5V or 2.6V   32 Meg x 16   66-pin TSOP
| MT46V128M4FN   2.5V or 2.6V   128 Meg x 4   60-ball FBGA
| MT46V64M8FN   2.5V or 2.6V   64 Meg x 8   60-ball FBGA
| MT46V32M16FN   2.5V or 2.6V   32 Meg x 16   60-ball FBGA
| MT46V128M4T37Z   2.5V or 2.6V   128 Meg x 4   Bare Die
| MT46V64M8T37Z   2.5V or 2.6V   64 Meg x 8   Bare Die
| MT46V32M16T37Z   2.5V or 2.6V   32 Meg x 16   Bare Die
[IBIS Ver]   4.0
[File name]   t37z.ibs
[File Rev]   2.3
[Date]   10/22/2009
[Source]   From silicon level SPICE model at Micron Technology, Inc.
   For support e-mail modelsupport@micron.com
[Notes]   Rev 2.0: 08/25/2005
   -Model matched to latest silicon measurements
   Rev 2.1: 11/21/2005
   -Updated FBGA package capacitance
   -Updated c_comp for all the models
   -Model updated to latest design revision
   -Added IBIS Quality Notes
   Rev 2.2: 07/09/2008
   - Combined models for all speed grades into a single file
   Rev 2.3: 10/22/2009
   - Matched C_comp to latest measurements
   - updated FBGA and TSOP package parasitics
   - added Bare Die Components
   - model data extracted from HSPICE model revision 2.3
   - IQ SUMMARY: Overall Quality of component and models Level
   2b. See Micron IBIS Model Quality Report for full IQ SUMMARY
   - Typ and slow corner V-t curves in the following DQ* models
   are shifted relative to strong corner V-t curve
   to contain all 3 corners within appropriate V-t window
   Models   Typ   Slow   V-t duration
   DQ_FULL_333   -200ps   -600ps   3.00ns
   DQ_HALF_333   -200ps   -600ps   3.00ns
   DQ_FULL_400   -250ps   -650ps   2.50ns
   DQ_HALF_400   -250ps   -650ps   2.50ns
   - Due to the shift in typ and slow corners, the V-t curves
   may overlap each other. This does not effect the accuracy
   of the IBIS data.
   - Models for 266, 333, 400 speed grades are included,
   selected through [Model Selector]. Models *_333 are
   applicable for speed grades 266/333 Mbps and models
   *_400 are applicable for speed grade 400 Mbps
[Disclaimer]  This software code and all associated documentation, comments
              or other information (collectively "Software") is provided
              "AS IS" without warranty of any kind. MICRON TECHNOLOGY, INC.
              ("MTI") EXPRESSLY DISCLAIMS ALL WARRANTIES EXPRESS OR IMPLIED,
              INCLUDING BUT NOT LIMITED TO, NONINFRINGEMENT OF THIRD PARTY
              RIGHTS, AND ANY IMPLIED WARRANTIES OF MERCHANTABILITY OR
              FITNESS FOR ANY PARTICULAR PURPOSE. MTI DOES NOT WARRANT THAT
              THE SOFTWARE WILL MEET YOUR REQUIREMENTS, OR THAT THE
              OPERATION OF THE SOFTWARE WILL BE UNINTERRUPTED OR ERROR-FREE.
              FURTHERMORE, MTI DOES NOT MAKE ANY REPRESENTATIONS REGARDING
              THE USE OR THE RESULTS OF THE USE OF THE SOFTWARE IN TERMS OF
              ITS CORRECTNESS, ACCURACY, RELIABILITY, OR OTHERWISE. THE
              ENTIRE RISK ARISING OUT OF USE OR PERFORMANCE OF THE SOFTWARE
              REMAINS WITH YOU. IN NO EVENT SHALL MTI, ITS AFFILIATED
              COMPANIES OR THEIR SUPPLIERS BE LIABLE FOR ANY DIRECT,
              INDIRECT, CONSEQUENTIAL, INCIDENTAL, OR SPECIAL DAMAGES
              (INCLUDING, WITHOUT LIMITATION, DAMAGES FOR LOSS OF PROFITS,
              BUSINESS INTERRUPTION, OR LOSS OF INFORMATION) ARISING OUT OF
              YOUR USE OF OR INABILITY TO USE THE SOFTWARE, EVEN IF MTI HAS
              BEEN ADVISED OF THE POSSIBILITY OF SUCH DAMAGES. Because some
              jurisdictions prohibit the exclusion or limitation of
              liability for consequential or incidental damages, the above
              limitation may not apply to you.
[Copyright]   Copyright 2005 Micron Technology, Inc. All Rights Reserved.
|   COMPONENT: MT46V128M4TG
[Component]   MT46V128M4TG
[Manufacturer]  Micron Technology, Inc.
[Package]  | TSOP package
|   typ   min   max
R_pkg   148.8m   136.8m   158.2m
L_pkg   4.13nH   2.48nH   6.10nH
C_pkg   1.19pF   0.82pF   1.39pF
[Pin]   signal_name   model_name   R_pin   L_pin   C_pin
1   VDD   POWER   109.9m   1.24nH   1.06pF
2   NF   NC
3   VDDQ   POWER   158.1m   5.78nH   1.40pF
4   NC   NC
5   DQ0   DQ_FULL   158.2m   5.07nH   1.34pF
6   VSSQ   GND   156.8m   4.73nH   NA
7   NC   NC
8   NF   NC
9   VDDQ   POWER   150.8m   3.69nH   1.22pF
10   NC   NC
11   DQ1   DQ_FULL   145.1m   3.25nH   1.13pF
12   VSSQ   GND   143.8m   3.11nH   NA
13   NC   NC
14   NC   NC
15   VDDQ   POWER   136.1m   2.59nH   0.88pF
16   NC   NC
17   NC   NC
18   VDD   POWER   134.0m   2.48nH   0.81pF
19   NC   NC
20   NC   NC
21   WE#   INPUT   139.0m   2.79nH   1.00pF
22   CAS#   INPUT   140.6m   2.97nH   1.03pF
23   RAS#   INPUT   140.9m   3.11nH   1.08pF
24   CS#   INPUT   143.7m   3.28nH   1.13pF
25   NC   NC
26   BA0   INPUT   148.4m   3.88nH   1.22pF
27   BA1   INPUT   150.4m   4.21nH   1.25pF
28   A10_AP   INPUT   152.0m   4.55nH   1.28pF
29   A0   INPUT   153.8m   4.92nH   1.31pF
30   A1   INPUT   154.5m   5.27nH   1.36pF
31   A2   INPUT   155.2m   5.63nH   1.39pF
32   A3   INPUT   154.6m   6.07nH   1.36pF
33   VDD   POWER   109.9m   1.24nH   1.06pF
34   VSS   GND   109.9m   1.24nH   NA
35   A4   INPUT   154.8m   6.10nH   1.35pF
36   A5   INPUT   155.4m   5.66nH   1.39pF
37   A6   INPUT   154.8m   5.26nH   1.34pF
38   A7   INPUT   153.8m   4.88nH   1.31pF
39   A8   INPUT   152.7m   4.53nH   1.28pF
40   A9   INPUT   151.1m   4.19nH   1.25pF
41   A11   INPUT   149.6m   3.86nH   1.21pF
42   A12   INPUT2   148.4m   3.58nH   1.14pF
43   NC   NC
44   CKE   INPUT   148.4m   3.58nH   1.14pF
45   CK   CLK_INPUT   141.9m   2.93nH   0.99pF
46   CK#   CLK_INPUT   140.3m   2.76nH   0.96pF
47   DM   DM_INPUT   138.7m   2.63nH   0.93pF
48   VSS   GND   134.3m   2.46nH   NA
49   VREF   POWER   133.3m   2.41nH   0.85pF
50   NC   NC
51   DQS   DQ2_FULL   136.8m   2.48nH   0.82pF
52   VSSQ   GND   137.7m   2.55nH   NA
53   NC   NC
54   NC   NC
55   VDDQ   POWER   144.6m   3.06nH   1.05pF
56   DQ2   DQ_FULL   145.7m   3.20nH   1.09pF
57   NC   NC
58   VSSQ   GND   150.9m   3.68nH   NA
59   NF   NC
60   NC   NC
61   VDDQ   POWER   156.5m   4.73nH   1.30pF
62   DQ3   DQ_FULL   157.9m   5.07nH   1.33pF
63   NC   NC
64   VSSQ   GND   158.2m   5.79nH   1.40pF
65   NF   NC
66   VSS   GND   109.9m   1.24nH   NA
|**********************DIFF PIN*********************************************
[Diff_pin]   inv_pin   vdiff   tdelay_typ   tdelay_min   tdelay_max
   45   46   .360V   0ns   NA   NA
|   COMPONENT: MT46V64M8TG
[Component]   MT46V64M8TG
[Manufacturer]  Micron Technology, Inc.
[Package]  | TSOP package
|   typ   min   max
R_pkg   149.6m   136.8m   158.2m
L_pkg   4.25nH   2.48nH   6.19nH
C_pkg   1.20pF   0.82pF   1.39pF
[Pin]   signal_name   model_name   R_pin   L_pin   C_pin
1   VDD   POWER   109.9m   1.24nH   1.06pF
2   DQ0   DQ_FULL   157.2m   6.18nH   1.34pF
3   VDDQ   POWER   158.1m   5.78nH   1.40pF
4   NC   NC
5   DQ1   DQ_FULL   158.2m   5.07nH   1.34pF
6   VSSQ   GND   156.8m   4.73nH   NA
7   NC   NC
8   DQ2   DQ_FULL   153.4m   4.03nH   1.26pF
9   VDDQ   POWER   150.8m   3.69nH   1.22pF
10   NC   NC
11   DQ3   DQ_FULL   145.1m   3.25nH   1.13pF
12   VSSQ   GND   143.8m   3.11nH   NA
13   NC   NC
14   NC   NC
15   VDDQ   POWER   136.1m   2.59nH   0.88pF
16   NC   NC
17   NC   NC
18   VDD   POWER   134.0m   2.48nH   0.81pF
19   NC   NC
20   NC   NC
21   WE#   INPUT   139.0m   2.79nH   1.00pF
22   CAS#   INPUT   140.6m   2.97nH   1.03pF
23   RAS#   INPUT   140.9m   3.11nH   1.08pF
24   CS#   INPUT   143.7m   3.28nH   1.13pF
25   NC   NC
26   BA0   INPUT   148.4m   3.88nH   1.22pF
27   BA1   INPUT   150.4m   4.21nH   1.25pF
28   A10_AP   INPUT   152.0m   4.55nH   1.28pF
29   A0   INPUT   153.8m   4.92nH   1.31pF
30   A1   INPUT   154.5m   5.27nH   1.36pF
31   A2   INPUT   155.2m   5.63nH   1.39pF
32   A3   INPUT   154.6m   6.07nH   1.36pF
33   VDD   POWER   109.9m   1.24nH   1.06pF
34   VSS   GND   109.9m   1.24nH   NA
35   A4   INPUT   154.8m   6.10nH   1.35pF
36   A5   INPUT   155.4m   5.66nH   1.39pF
37   A6   INPUT   154.8m   5.26nH   1.34pF
38   A7   INPUT   153.8m   4.88nH   1.31pF
39   A8   INPUT   152.7m   4.53nH   1.28pF
40   A9   INPUT   151.1m   4.19nH   1.25pF
41   A11   INPUT   149.6m   3.86nH   1.21pF
42   A12   INPUT2   148.4m   3.58nH   1.14pF
43   NC   NC
44   CKE   INPUT   148.4m   3.58nH   1.14pF
45   CK   CLK_INPUT   141.9m   2.93nH   0.99pF
46   CK#   CLK_INPUT   140.3m   2.76nH   0.96pF
47   DM   DM_INPUT   138.7m   2.63nH   0.93pF
48   VSS   GND   134.3m   2.46nH   NA
49   VREF   POWER   133.3m   2.41nH   0.85pF
50   NC   NC
51   DQS   DQ2_FULL   136.8m   2.48nH   0.82pF
52   VSSQ   GND   137.7m   2.55nH   NA
53   NC   NC
54   NC   NC
55   VDDQ   POWER   144.6m   3.06nH   1.05pF
56   DQ4   DQ_FULL   145.7m   3.20nH   1.09pF
57   NC   NC
58   VSSQ   GND   150.9m   3.68nH   NA
59   DQ5   DQ_FULL   153.2m   4.03nH   1.22pF
60   NC   NC
61   VDDQ   POWER   156.5m   4.73nH   1.30pF
62   DQ6   DQ_FULL   157.9m   5.07nH   1.33pF
63   NC   NC
64   VSSQ   GND   158.2m   5.79nH   1.40pF
65   DQ7   DQ_FULL   157.5m   6.19nH   1.34pF
66   VSS   GND   109.9m   1.24nH   NA
|**********************DIFF PIN*********************************************
[Diff_pin]   inv_pin   vdiff   tdelay_typ   tdelay_min   tdelay_max
   45   46   .360V   0ns   NA   NA
|   COMPONENT: MT46V32M16TG
[Component]   MT46V32M16TG
[Manufacturer]  Micron Technology, Inc.
[Package]  | TSOP package
|   typ   min   max
R_pkg   149.2m   134.5m   159.4m
L_pkg   4.13nH   2.48nH   6.19nH
C_pkg   1.19pF   0.82pF   1.39pF
[Pin]   signal_name   model_name   R_pin   L_pin   C_pin
1   VDD   POWER   109.9m   1.24nH   1.06pF
2   DQ0   DQ   157.2m   6.18nH   1.34pF
3   VDDQ   POWER   158.1m   5.78nH   1.40pF
4   DQ1   DQ   159.4m   5.43nH   1.37pF
5   DQ2   DQ   158.2m   5.07nH   1.34pF
6   VSSQ   GND   156.8m   4.73nH   NA
7   DQ3   DQ   155.0m   4.37nH   1.30pF
8   DQ4   DQ   153.4m   4.03nH   1.26pF
9   VDDQ   POWER   150.8m   3.69nH   1.22pF
10   DQ5   DQ   146.9m   3.36nH   1.19pF
11   DQ6   DQ   145.1m   3.25nH   1.13pF
12   VSSQ   GND   143.8m   3.11nH   NA
13   DQ7   DQ   140.9m   2.93nH   1.03pF
14   NC   NC
15   VDDQ   POWER   136.1m   2.59nH   0.88pF
16   LDQS   DQ2   134.5m   2.50nH   0.84pF
17   NC   NC
18   VDD   POWER   134.0m   2.48nH   0.81pF
19   NC   NC
20   LDM   DM_INPUT   136.8m   2.66nH   0.94pF
21   WE#   INPUT   139.0m   2.79nH   1.00pF
22   CAS#   INPUT   140.6m   2.97nH   1.03pF
23   RAS#   INPUT   140.9m   3.11nH   1.08pF
24   CS#   INPUT   143.7m   3.28nH   1.13pF
25   NC   NC
26   BA0   INPUT   148.4m   3.88nH   1.22pF
27   BA1   INPUT   150.4m   4.21nH   1.25pF
28   A10_AP   INPUT   152.0m   4.55nH   1.28pF
29   A0   INPUT   153.8m   4.92nH   1.31pF
30   A1   INPUT   154.5m   5.27nH   1.36pF
31   A2   INPUT   155.2m   5.63nH   1.39pF
32   A3   INPUT   154.6m   6.07nH   1.36pF
33   VDD   POWER   109.9m   1.24nH   1.06pF
34   VSS   GND   109.9m   1.24nH   NA
35   A4   INPUT   154.8m   6.10nH   1.35pF
36   A5   INPUT   155.4m   5.66nH   1.39pF
37   A6   INPUT   154.8m   5.26nH   1.34pF
38   A7   INPUT   153.8m   4.88nH   1.31pF
39   A8   INPUT   152.7m   4.53nH   1.28pF
40   A9   INPUT   151.1m   4.19nH   1.25pF
41   A11   INPUT   149.6m   3.86nH   1.21pF
42   A12   INPUT2   148.4m   3.58nH   1.14pF
43   NC   NC
44   CKE   INPUT   148.4m   3.58nH   1.14pF
45   CK   CLK_INPUT   141.9m   2.93nH   0.99pF
46   CK#   CLK_INPUT   140.3m   2.76nH   0.96pF
47   UDM   DM_INPUT   138.7m   2.63nH   0.93pF
48   VSS   GND   134.3m   2.46nH   NA
49   VREF   POWER   133.3m   2.41nH   0.85pF
50   NC   NC
51   UDQS   DQ2   136.8m   2.48nH   0.82pF
52   VSSQ   GND   137.7m   2.55nH   NA
53   NC   NC
54   DQ8   DQ2   142.1m   2.91nH   0.99pF
55   VDDQ   POWER   144.6m   3.06nH   1.05pF
56   DQ9   DQ   145.7m   3.20nH   1.09pF
57   DQ10   DQ   147.2m   3.33nH   1.15pF
58   VSSQ   GND   150.9m   3.68nH   NA
59   DQ11   DQ   153.2m   4.03nH   1.22pF
60   DQ12   DQ   155.0m   4.38nH   1.26pF
61   VDDQ   POWER   156.5m   4.73nH   1.30pF
62   DQ13   DQ   157.9m   5.07nH   1.33pF
63   DQ14   DQ   159.2m   5.42nH   1.35pF
64   VSSQ   GND   158.2m   5.79nH   1.40pF
65   DQ15   DQ   157.5m   6.19nH   1.34pF
66   VSS   GND   109.9m   1.24nH   NA
|**********************DIFF PIN*********************************************
[Diff_pin]   inv_pin   vdiff   tdelay_typ   tdelay_min   tdelay_max
   45   46   .360V   0ns   NA   NA
|   COMPONENT: MT46V128M4FN  (60-Ball FBGA)
[Component]   MT46V128M4FN
[Manufacturer]  Micron Technology, Inc.
[Package]  | 10mm x 12.5mm FBGA
|   typ   min   max
R_pkg   156.5m   112.8m   216.5m
L_pkg   1.81nH   1.16nH   2.91nH
C_pkg   0.44pF   0.21pF   0.62pF
[Pin]   signal_name   model_name   R_pin   L_pin   C_pin
A1   VSSQ   GND   205.4m   2.66nH   NA
A2   NF   NC
A3   VSS   GND   153.3m   1.65nH   NA
A7   VDD   POWER   146.6m   1.55nH   0.55pF
A8   NF   NC
A9   VDDQ   POWER   213.8m   2.79nH   0.54pF
B1   NC   NC
B2   VDDQ   POWER   165.6m   1.98nH   0.49pF
B3   DQ3   DQ_FULL   140.7m   1.50nH   0.27pF
B7   DQ0   DQ_FULL   149.3m   1.61nH   0.28pF
B8   VSSQ   GND   174.2m   2.08nH   NA
B9   NC   NC
C1   NC   NC
C2   VSSQ   GND   153.6m   1.81nH   NA
C3   NF   NC
C7   NF   NC
C8   VDDQ   POWER   158.4m   1.91nH   0.44pF
C9   NC   NC
D1   NC   NC
D2   VDDQ   POWER   147.4m   1.68nH   0.44pF
D3   DQ2   DQ_FULL   118.3m   1.20nH   0.21pF
D7   DQ3   DQ_FULL   123.1m   1.24nH   0.23pF
D8   VSSQ   GND   152.0m   1.75nH   NA
D9   NC   NC
E1   NC   NC
E2   VSSQ   GND   158.6m   1.77nH   NA
E3   DQS   DQ2_FULL   115.8m   1.17nH   0.45pF
E7   NC   NC
E8   VDDQ   POWER   161.1m   1.82nH   0.48pF
E9   NC   NC
F1   VREF   POWER   171.8m   2.19nH   0.41pF
F2   VSS   GND   74.3m   0.87nH   NA
F3   DM   DM_INPUT   122.3m   1.24nH   0.43pF
F7   NC   NC
F8   VDD   POWER   76.8m   0.92nH   0.47pF
F9   NC   NC
G2   CLK   CLK_INPUT   156.9m   1.78nH   0.43pF
G3   CLK_   CLK_INPUT   113.4m   1.16nH   0.42pF
G7   WE_   INPUT   112.8m   1.17nH   0.42pF
G8   CAS_   INPUT   157.9m   1.82nH   0.43pF
H2   A12   INPUT2   174.9m   1.99nH   0.41pF
H3   CKE   INPUT   124.1m   1.34nH   0.44pF
H7   RAS_   INPUT   125.8m   1.36nH   0.44pF
H8   CS_   INPUT   179.7m   2.03nH   0.42pF
J2   A11   INPUT   164.2m   1.95nH   0.40pF
J3   A9   INPUT   136.8m   1.46nH   0.41pF
J7   BA1   INPUT   140.0m   1.50nH   0.46pF
J8   BA0   INPUT   167.7m   1.98nH   0.41pF
K2   A8   INPUT   181.1m   2.23nH   0.50pF
K3   A7   INPUT   157.1m   1.79nH   0.57pF
K7   A0   INPUT   159.8m   1.83nH   0.49pF
K8   A10   INPUT   184.5m   2.28nH   0.47pF
L2   A6   INPUT   194.8m   2.54nH   0.57pF
L3   A5   INPUT   175.7m   2.10nH   0.59pF
L7   A2   INPUT   177.5m   2.13nH   0.55pF
L8   A1   INPUT   199.0m   2.57nH   0.52pF
M2   A4   INPUT   211.9m   2.85nH   0.62pF
M3   VSS   GND   189.7m   2.40nH   NA
M7   VDD   POWER   201.3m   2.48nH   0.49pF
M8   A3   INPUT   216.5m   2.91nH   0.58pF
|**********************DIFF PIN*********************************************
[Diff_pin]   inv_pin   vdiff   tdelay_typ   tdelay_min   tdelay_max
   G2   G3   .360V   0ns   NA   NA
|   COMPONENT: MT46V64M8FN   (60-Ball FBGA)
[Component]   MT46V64M8FN
[Manufacturer]  Micron Technology, Inc.
[Package]  | 10mm x 12.5mm FBGA
|   typ   min   max
R_pkg   156.8m   112.8m   216.5m
L_pkg   1.81nH   1.16nH   2.91nH
C_pkg   0.44pF   0.21pF   0.62pF
[Pin]   signal_name   model_name   R_pin   L_pin   C_pin
A1   VSSQ   GND   205.4m   2.66nH   NA
A2   DQ7   DQ_FULL   180.9m   2.14nH   0.56pF
A3   VSS   GND   153.3m   1.65nH   NA
A7   VDD   POWER   146.6m   1.55nH   0.55pF
A8   DQ0   DQ_FULL   194.3m   2.25nH   0.57pF
A9   VDDQ   POWER   213.8m   2.79nH   0.54pF
B1   NC   NC
B2   VDDQ   POWER   165.6m   1.98nH   0.49pF
B3   DQ6   DQ_FULL   140.7m   1.50nH   0.27pF
B7   DQ1   DQ_FULL   149.3m   1.61nH   0.28pF
B8   VSSQ   GND   174.2m   2.08nH   NA
B9   NC   NC
C1   NC   NC
C2   VSSQ   GND   153.6m   1.81nH   NA
C3   DQ5   DQ_FULL   127.9m   1.31nH   0.24pF
C7   DQ2   DQ_FULL   133.8m   1.40nH   0.24pF
C8   VDDQ   POWER   158.4m   1.91nH   0.44pF
C9   NC   NC
D1   NC   NC
D2   VDDQ   POWER   147.4m   1.68nH   0.44pF
D3   DQ4   DQ_FULL   118.3m   1.20nH   0.21pF
D7   DQ3   DQ_FULL   123.1m   1.24nH   0.23pF
D8   VSSQ   GND   152.0m   1.75nH   NA
D9   NC   NC
E1   NC   NC
E2   VSSQ   GND   158.6m   1.77nH   NA
E3   DQS   DQ2_FULL   115.8m   1.17nH   0.45pF
E7   NC   NC
E8   VDDQ   POWER   161.1m   1.82nH   0.48pF
E9   NC   NC
F1   VREF   POWER   171.8m   2.19nH   0.41pF
F2   VSS   GND   74.3m   0.87nH   NA
F3   DM   DM_INPUT   122.3m   1.24nH   0.43pF
F7   NC   NC
F8   VDD   POWER   76.8m   0.92nH   0.47pF
F9   NC   NC
G2   CLK   CLK_INPUT   156.9m   1.78nH   0.43pF
G3   CLK_   CLK_INPUT   113.4m   1.16nH   0.42pF
G7   WE_   INPUT   112.8m   1.17nH   0.42pF
G8   CAS_   INPUT   157.9m   1.82nH   0.43pF
H2   A12   INPUT2   174.9m   1.99nH   0.41pF
H3   CKE   INPUT   124.1m   1.34nH   0.44pF
H7   RAS_   INPUT   125.8m   1.36nH   0.44pF
H8   CS_   INPUT   179.7m   2.03nH   0.42pF
J2   A11   INPUT   164.2m   1.95nH   0.40pF
J3   A9   INPUT   136.8m   1.46nH   0.41pF
J7   BA1   INPUT   140.0m   1.50nH   0.46pF
J8   BA0   INPUT   167.7m   1.98nH   0.41pF
K2   A8   INPUT   181.1m   2.23nH   0.50pF
K3   A7   INPUT   157.1m   1.79nH   0.57pF
K7   A0   INPUT   159.8m   1.83nH   0.49pF
K8   A10   INPUT   184.5m   2.28nH   0.47pF
L2   A6   INPUT   194.8m   2.54nH   0.57pF
L3   A5   INPUT   175.7m   2.10nH   0.59pF
L7   A2   INPUT   177.5m   2.13nH   0.55pF
L8   A1   INPUT   199.0m   2.57nH   0.52pF
M2   A4   INPUT   211.9m   2.85nH   0.62pF
M3   VSS   GND   189.7m   2.40nH   NA
M7   VDD   POWER   201.3m   2.48nH   0.49pF
M8   A3   INPUT   216.5m   2.91nH   0.58pF
|**********************DIFF PIN*********************************************
[Diff_pin]   inv_pin   vdiff   tdelay_typ   tdelay_min   tdelay_max
   G2   G3   .360V   0ns   NA   NA
|   COMPONENT: MT46V32M16FN   (60-Ball FBGA)
[Component]   MT46V32M16FN
[Manufacturer]  Micron Technology, Inc.
[Package]  | 10mm x 12.5mm FBGA
|   typ   min   max
R_pkg   163.7m   112.8m   226.9m
L_pkg   1.92nH   1.16nH   2.91nH
C_pkg   0.44pF   0.21pF   0.62pF
[Pin]   signal_name   model_name   R_pin   L_pin   C_pin
A1   VSSQ   GND   205.4m   2.66nH   NA
A2   DQ15   DQ   180.9m   2.14nH   0.56pF
A3   VSS   GND   153.3m   1.65nH   NA
A7   VDD   POWER   146.6m   1.55nH   0.55pF
A8   DQ0   DQ   194.3m   2.25nH   0.57pF
A9   VDDQ   POWER   213.8m   2.79nH   0.54pF
B1   DQ14   DQ   218.5m   2.73nH   0.51pF
B2   VDDQ   POWER   165.6m   1.98nH   0.49pF
B3   DQ13   DQ   140.7m   1.50nH   0.27pF
B7   DQ2   DQ   149.3m   1.61nH   0.28pF
B8   VSSQ   GND   174.2m   2.08nH   NA
B9   DQ1   DQ   226.9m   2.85nH   0.51pF
C1   DQ12   DQ   201.4m   2.57nH   0.49pF
C2   VSSQ   GND   153.6m   1.81nH   NA
C3   DQ11   DQ   127.9m   1.31nH   0.24pF
C7   DQ4   DQ   133.8m   1.40nH   0.24pF
C8   VDDQ   POWER   158.4m   1.91nH   0.44pF
C9   DQ3   DQ   210.1m   2.64nH   0.49pF
D1   DQ10   DQ   188.3m   2.41nH   0.43pF
D2   VDDQ   POWER   147.4m   1.68nH   0.44pF
D3   DQ9   DQ   118.3m   1.20nH   0.21pF
D7   DQ6   DQ   123.1m   1.24nH   0.23pF
D8   VSSQ   GND   152.0m   1.75nH   NA
D9   DQ5   DQ   197.3m   2.49nH   0.43pF
E1   DQ8   DQ2   186.4m   2.32nH   0.45pF
E2   VSSQ   GND   158.6m   1.77nH   NA
E3   UDQS   DQ2   115.8m   1.17nH   0.45pF
E7   LDQS   DQ2   117.0m   1.20nH   0.42pF
E8   VDDQ   POWER   161.1m   1.82nH   0.48pF
E9   DQ7   DQ   191.5m   2.34nH   0.47pF
F1   VREF   POWER   171.8m   2.19nH   0.41pF
F2   VSS   GND   74.3m   0.87nH   NA
F3   UDM   DM_INPUT   122.3m   1.24nH   0.43pF
F7   LDM   DM_INPUT   118.8m   1.24nH   0.42pF
F8   VDD   POWER   76.8m   0.92nH   0.47pF
F9   NC   NC
G2   CLK   CLK_INPUT   156.9m   1.78nH   0.43pF
G3   CLK_   CLK_INPUT   113.4m   1.16nH   0.42pF
G7   WE_   INPUT   112.8m   1.17nH   0.42pF
G8   CAS_   INPUT   157.9m   1.82nH   0.43pF
H2   A12   INPUT2   174.9m   1.99nH   0.41pF
H3   CKE   INPUT   124.1m   1.34nH   0.44pF
H7   RAS_   INPUT   125.8m   1.36nH   0.44pF
H8   CS_   INPUT   179.7m   2.03nH   0.42pF
J2   A11   INPUT   164.2m   1.95nH   0.40pF
J3   A9   INPUT   136.8m   1.46nH   0.41pF
J7   BA1   INPUT   140.0m   1.50nH   0.46pF
J8   BA0   INPUT   167.7m   1.98nH   0.41pF
K2   A8   INPUT   181.1m   2.23nH   0.50pF
K3   A7   INPUT   157.1m   1.79nH   0.57pF
K7   A0   INPUT   159.8m   1.83nH   0.49pF
K8   A10   INPUT   184.5m   2.28nH   0.47pF
L2   A6   INPUT   194.8m   2.54nH   0.57pF
L3   A5   INPUT   175.7m   2.10nH   0.59pF
L7   A2   INPUT   177.5m   2.13nH   0.55pF
L8   A1   INPUT   199.0m   2.57nH   0.52pF
M2   A4   INPUT   211.9m   2.85nH   0.62pF
M3   VSS   GND   189.7m   2.40nH   NA
M7   VDD   POWER   201.3m   2.48nH   0.49pF
M8   A3   INPUT   216.5m   2.91nH   0.58pF
|**********************DIFF PIN*********************************************
[Diff_pin]   inv_pin   vdiff   tdelay_typ   tdelay_min   tdelay_max
   G2   G3   .360V   0ns   NA   NA
|   COMPONENT: MT46V128M4T37Z
[Component]   MT46V128M4T37Z
[Manufacturer]  Micron Technology, Inc.
[Package]  | Bare Die
|   typ   min   max
R_pkg   0.001m   0.001m   0.001m
L_pkg   0.001nH   0.001nH   0.001nH
C_pkg   0.001pf   0.001pf   0.001pf
[Pin]   signal_name   model_name   R_pin   L_pin   C_pin
1   VBB   POWER
2   DNU   NC
3   VSS   GND
4   VDD   POWER
5   DNU   NC
6   DNU   NC
7   VSSQ   GND
8   VDDQ   POWER
9   DNU   NC
10   DNU   NC
11   DQ3   DQ_FULL
12   DQ0   DQ_FULL
13   VDDQ   POWER
14   VSSQ   GND
15   DNU   NC
16   DNU   NC
17   DNU   NC
18   DNU   NC
19   VSSQ   GND
20   VDDQ   POWER
21   DNU   NC
22   DNU   NC
23   DQ2   DQ_FULL
24   DQ1   DQ_FULL
25   VDDQ   POWER
26   VSSQ   GND
27   DNU   NC
28   DNU   NC
29   VSSQ   GND
30   VDDQ   POWER
31   DQS   DQ2_FULL
32   DNU   NC
33   VREF   POWER
34   VSS1   GND
35   VDD1   POWER
36   VDD   POWER
37   VSS   GND
38   DM   DM_INPUT
39   DNU   NC
40   DNU   NC
41   WE#   INPUT
42   CLK#   CLK_INPUT
43   CAS#   INPUT
44   CLK   CLK_INPUT
45   RAS#   INPUT
46   CKE   INPUT
47   CS#   INPUT
48   A12   INPUT2
49   BA0   INPUT
50   A11   INPUT
51   BA1   INPUT
52   A9   INPUT
53   A10   INPUT
54   A8   INPUT
55   A0   INPUT
56   A7   INPUT
57   A1   INPUT
58   A6   INPUT
59   A2   INPUT
60   A5   INPUT
61   A3   INPUT
62   A4   INPUT
63   VDD   POWER
64   VSS   GND
65   DNU   NC
66   DNU   NC
|**********************DIFF PIN*********************************************
[Diff_pin]   inv_pin   vdiff   tdelay_typ   tdelay_min   tdelay_max
   44   42   .360V   0ns   NA   NA
|   COMPONENT: MT46V64M8T37Z
[Component]   MT46V64M8T37Z
[Manufacturer]  Micron Technology, Inc.
[Package]  | Bare Die
|   typ   min   max
R_pkg   0.001m   0.001m   0.001m
L_pkg   0.001nH   0.001nH   0.001nH
C_pkg   0.001pf   0.001pf   0.001pf
[Pin]   signal_name   model_name   R_pin   L_pin   C_pin
1   VBB   POWER
2   DNU   NC
3   VSS   GND
4   VDD   POWER
5   DQ7   DQ_FULL
6   DQ0   DQ_FULL
7   VSSQ   GND
8   VDDQ   POWER
9   DNU   NC
10   DNU   NC
11   DQ6   DQ_FULL
12   DQ1   DQ_FULL
13   VDDQ   POWER
14   VSSQ   GND
15   DNU   NC
16   DNU   NC
17   DQ5   DQ_FULL
18   DQ2   DQ_FULL
19   VSSQ   GND
20   VDDQ   POWER
21   DNU   NC
22   DNU   NC
23   DQ4   DQ_FULL
24   DQ3   DQ_FULL
25   VDDQ   POWER
26   VSSQ   GND
27   DNU   NC
28   DNU   NC
29   VSSQ   GND
30   VDDQ   POWER
31   DQS   DQ2_FULL
32   DNU   NC
33   VREF   POWER
34   VSS1   GND
35   VDD1   POWER
36   VDD   POWER
37   VSS   GND
38   DM   DM_INPUT
39   DNU   NC
40   DNU   NC
41   WE#   INPUT
42   CLK#   CLK_INPUT
43   CAS#   INPUT
44   CLK   CLK_INPUT
45   RAS#   INPUT
46   CKE   INPUT
47   CS#   INPUT
48   A12   INPUT2
49   BA0   INPUT
50   A11   INPUT
51   BA1   INPUT
52   A9   INPUT
53   A10   INPUT
54   A8   INPUT
55   A0   INPUT
56   A7   INPUT
57   A1   INPUT
58   A6   INPUT
59   A2   INPUT
60   A5   INPUT
61   A3   INPUT
62   A4   INPUT
63   VDD   POWER
64   VSS   GND
65   DNU   NC
66   DNU   NC
|**********************DIFF PIN*********************************************
[Diff_pin]   inv_pin   vdiff   tdelay_typ   tdelay_min   tdelay_max
   44   42   .360V   0ns   NA   NA
|   COMPONENT: MT46V32M16T37Z
[Component]   MT46V32M16T37Z
[Manufacturer]  Micron Technology, Inc.
[Package]  | Bare Die
|   typ   min   max
R_pkg   0.001m   0.001m   0.001m
L_pkg   0.001nH   0.001nH   0.001nH
C_pkg   0.001pf   0.001pf   0.001pf
[Pin]   signal_name   model_name   R_pin   L_pin   C_pin
1   VBB   POWER
2   DNU   NC
3   VSS   GND
4   VDD   POWER
5   DQ15   DQ
6   DQ0   DQ
7   VSSQ   GND
8   VDDQ   POWER
9   DQ14   DQ
10   DQ1   DQ
11   DQ13   DQ
12   DQ2   DQ
13   VDDQ   POWER
14   VSSQ   GND
15   DQ12   DQ
16   DQ3   DQ
17   DQ11   DQ
18   DQ4   DQ
19   VSSQ   GND
20   VDDQ   POWER
21   DQ10   DQ
22   DQ5   DQ
23   DQ9   DQ
24   DQ6   DQ
25   VDDQ   POWER
26   VSSQ   GND
27   DQ8   DQ2
28   DQ7   DQ
29   VSSQ   GND
30   VDDQ   POWER
31   UDQS   DQ2
32   LDQS   DQ2
33   VREF   POWER
34   VSS1   GND
35   VDD1   POWER
36   VDD   POWER
37   VSS   GND
38   UDM   DM_INPUT
39   LDM   DM_INPUT
40   DNU   NC
41   WE#   INPUT
42   CLK#   CLK_INPUT
43   CAS#   INPUT
44   CLK   CLK_INPUT
45   RAS#   INPUT
46   CKE   INPUT
47   CS#   INPUT
48   A12   INPUT2
49   BA0   INPUT
50   A11   INPUT
51   BA1   INPUT
52   A9   INPUT
53   A10   INPUT
54   A8   INPUT
55   A0   INPUT
56   A7   INPUT
57   A1   INPUT
58   A6   INPUT
59   A2   INPUT
60   A5   INPUT
61   A3   INPUT
62   A4   INPUT
63   VDD   POWER
64   VSS   GND
65   DNU   NC
66   DNU   NC
|**********************DIFF PIN*********************************************
[Diff_pin]   inv_pin   vdiff   tdelay_typ   tdelay_min   tdelay_max
   44   42   .360V   0ns   NA   NA
|***********************MODEL SELECTOR**************************************
[Model Selector] DQ
DQ_FULL_333   Full-Strength IO Driver for DDR1-266/333
DQ_HALF_333   54% Reduced Drive Strength IO Driver for DDR1-266/333
DQ_FULL_400   Full-Strength IO Driver for DDR1-400
DQ_HALF_400   54% Reduced Drive Strength IO Driver for DDR1-400
[Model Selector] DQ2
DQ2_FULL_333   Full-Strength IO Driver for DDR1-266/333
DQ2_HALF_333   54% Reduced Drive Strength IO Driver for DDR1-266/333
DQ2_FULL_400   Full-Strength IO Driver for DDR1-400
DQ2_HALF_400   54% Reduced Drive Strength IO Driver for DDR1-400
[Model Selector] DQ_FULL
DQ_FULL_333   Full-Strength IO Driver for DDR1-266/333
DQ_FULL_400   Full-Strength IO Driver for DDR1-400
[Model Selector] DQ2_FULL
DQ2_FULL_333   Full-Strength IO Driver for DDR1-266/333
DQ2_FULL_400   Full-Strength IO Driver for DDR1-400
[Model Selector] DM_INPUT
DM_333   DM INPUT for DDR1-266/333
DM_400   DM INPUT for DDR1-400
[Model Selector] INPUT
IN_333   INPUT for DDR1-266/333
IN_400   INPUT for DDR1-400
[Model Selector] INPUT2
IN2_333   INPUT for DDR1-266/333
IN2_400   INPUT for DDR1-400
[Model Selector] CLK_INPUT
CLK_333   CLK for DDR1-266/333
CLK_400   CLK for DDR1-400
| Models and submodels in the file (16): DQ_FULL_333 (I/O), DQ_HALF_333 (I/O), DQ2_FULL_333 (I/O), DQ2_HALF_333 (I/O), IN_333 (Input), IN2_333 (Input), CLK_333 (Input), DM_333 (Input), DQ_FULL_400 (I/O), DQ_HALF_400 (I/O), DQ2_FULL_400 (I/O), DQ2_HALF_400 (I/O), IN_400 (Input), IN2_400 (Input), CLK_400 (Input), DM_400 (Input)
